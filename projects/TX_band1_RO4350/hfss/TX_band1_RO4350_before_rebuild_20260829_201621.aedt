# Ansys Electronics Desktop project, version 2026.1
materials:
  air: permittivity=1.0006 permeability=1.0000004
  copper: permeability=0.999991 conductivity=58000000
  FR4_epoxy: permittivity=4.4 dielectric_loss_tangent=0.02
  pec: conductivity=1e+30
  RO4350B: permittivity=3.66 permeability=1 dielectric_loss_tangent=0.0037
  solder: conductivity=7000000
  vacuum: permittivity=1

design TX_band1_RO4350_v2 (HFSS 3D Layout)
ports:
  Port1, Port2: Properties{Reference=ETCH_BOTTOM:hfss_ground_plane Impedance=50ohm Magnitude=1V Phase=0deg Renormalize_Impedance=50ohm Renormalize Deembed_Distance=0mm Deembed Type="Single Strip Gap Source" HFSS_Type=Gap Orientation=Vertical Layer_Alignment=Upper Horizontal_Extent_Factor=5 Vertical_Extent_Factor=3 PEC_Launch_Width=0.05mm} Type=EdgePort SIwavePSIType=Default
setups:
  Setup_14to23G: SolveSetupType=HFSS PercentRefinementPerPass=30 MinNumberOfPasses=1 MinNumberOfConvergedPasses=1 Frequency=10GHz MeshSizeFactor=2 ViaNumSides=6 ViaMaterial=copper Style25DVia=Mesh
    sweep Sweep_14to23G_121pt: LINC 14.0GHz 23.0GHz 121; SAbsError=0.005 ZoPercentError=1 PassivityTolerance=0.0001 MaxSolutions=120 InterpUseSMatrix InterpUsePortImpedance InterpUseFullBasis MinSolvedFreq=0.01GHz AutoSMatOnlySolve MinFreqSMatrixOnlySolve=1MHz MagMinThreshold=0.01 InterpMinSolutions=0 FreqSweepType=kInterpolating
reports:
  S Parameter Plot1: dB(S(Port1,Port1)), dB(S(Port2,Port1)), dB(S(Port1,Port2)), dB(S(Port2,Port2)) vs Freq on Setup_14to23G : Sweep_14to23G_121pt; markers m1 at 15GHz, m2 at 17.7GHz, m3 at 19.35GHz, m4 at 22GHz
